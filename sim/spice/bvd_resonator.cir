* ============================================================
* BVD Resonator — AIN FBAR ~1 GHz  (batch mode, no GUI)
* ============================================================
* Single-port equivalent circuit:
*
*   Vin --- Lm --- Rm --- Cm --- GND
*    |                            |
*    +------------ C0 ------------+
*
* AIN FBAR typical @ 1 GHz:
*   Lm=100nH, Cm=250aF, Rm=0.5Ω, C0=2pF
*   fs = 1/(2π√(Lm·Cm)) = 1.006 GHz
*   Q  = 2π·fs·Lm/Rm    = 1257
* ============================================================

.title BVD AIN FBAR Resonator

* Cm = 250 fF (femtofarad, 250e-15) — gives fs = 1/(2π√(100n×250f)) = 1.007 GHz
Lm  in  n1  100n
Rm  n1  n2  0.5
Cm  n2  0   250e-15
C0  in  0   2p
Vin in  0   AC 1

.ac dec 2000 900meg 1100meg

.control
  set noaskquit
  run

  * Impedance magnitude: Z = V/I
  let Zmag   = abs(v(in) / i(Vin))
  * Phase via ph() which returns radians, convert to degrees
  let Zphase = ph(v(in) / i(Vin)) * 180 / PI

  wrdata sim/spice/out_bvd.dat Zmag Zphase

  * Extract resonant frequencies from min/max of |Z|
  meas ac Z_min   MIN Zmag
  meas ac Z_max   MAX Zmag
  meas ac f_at_Zmin MIN_AT Zmag
  meas ac f_at_Zmax MAX_AT Zmag

  echo "=== BVD Resonator Results ==="
  echo "Min |Z| (= Rm at series resonance, should be ~0.5 Ohm):"
  print Z_min
  echo "Max |Z| (at parallel resonance):"
  print Z_max
  echo "Frequency at min |Z| = fs:"
  print f_at_Zmin
  echo "Frequency at max |Z| = fp:"
  print f_at_Zmax
  echo "Q analytical = 2*pi*fs*Lm/Rm = 2*pi*1.007G*100n/0.5 = 1266"
  quit
.endc

.end
